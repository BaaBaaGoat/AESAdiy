# Ansys Electronics Desktop project, version 2018.1
materials:
  air: permittivity=1.0006 permeability=1.0000004
  copper: permeability=0.999991 conductivity=58000000
  FR4_epoxy: permittivity=4.6 dielectric_loss_tangent=0.02
  pc: permittivity=2.5 dielectric_loss_tangent=0.001
  pec: conductivity=1e+30
  vacuum: permittivity=1
  cyanate_ester: permittivity=3.8

design EMDesign2 (HFSS 3D Layout)
variables:
  x0 = 32.5mm  # optimise 20mm..40mm
  y0 = 32.5mm  # optimise 20mm..40mm
  y1 = 10.5mm  # optimise 0mm..12mm
ports:
  via_42: Properties{Impedance=50ohm Magnitude=1V Phase=0deg Renormalize_Impedence="50ohm + 0i ohm" Renormalize Deembed_Distance=0mm Deembed Type=Probe HFSS_Type=Gap(coax) Orientation=Horizontal Layer_Alignment=Upper Horizontal_Extent_Factor=5 Vertical_Extent_Factor=3 PEC_Launch_Width=0mm} Type=ProbePort Pin=via_42 Lower{LoadType=CoaxProbe Properties{Lower_R=0ohm Lower_L=0nH Lower_C=0pF Lower_Real=0ohm Lower_Imag=0ohm Lower_Magnitude=1V Lower_Phase=0deg Lower_Impedance=50ohm}} Material=copper ViaMesh=Wirebond Sides=3
  via_43: Properties{Impedance=50ohm Magnitude=1V Phase=0deg Renormalize_Impedence="50ohm + 0i ohm" Renormalize Deembed_Distance=0mm Deembed Type=Probe HFSS_Type=Gap(coax) Orientation=Horizontal Layer_Alignment=Upper Horizontal_Extent_Factor=5 Vertical_Extent_Factor=3 PEC_Launch_Width=0mm} Type=ProbePort Pin=via_43 Lower{LoadType=CoaxProbe Properties{Lower_R=0ohm Lower_L=0nH Lower_C=0pF Lower_Real=0ohm Lower_Imag=0ohm Lower_Magnitude=1V Lower_Phase=0deg Lower_Impedance=50ohm}} Material=copper ViaMesh=Wirebond Sides=3
  via_44: Properties{Impedance=50ohm Magnitude=1V Phase=0deg Renormalize_Impedence="50ohm + 0i ohm" Renormalize Deembed_Distance=0mm Deembed Type=Probe HFSS_Type=Gap(coax) Orientation=Horizontal Layer_Alignment=Upper Horizontal_Extent_Factor=5 Vertical_Extent_Factor=3 PEC_Launch_Width=0mm} Type=ProbePort Pin=via_44 Lower{LoadType=CoaxProbe Properties{Lower_R=0ohm Lower_L=0nH Lower_C=0pF Lower_Real=0ohm Lower_Imag=0ohm Lower_Magnitude=1V Lower_Phase=0deg Lower_Impedance=50ohm}} Material=copper ViaMesh=Wirebond Sides=3
  via_45: Properties{Impedance=50ohm Magnitude=1V Phase=0deg Renormalize_Impedence="50ohm + 0i ohm" Renormalize Deembed_Distance=0mm Deembed Type=Probe HFSS_Type=Gap(coax) Orientation=Horizontal Layer_Alignment=Upper Horizontal_Extent_Factor=5 Vertical_Extent_Factor=3 PEC_Launch_Width=0mm} Type=ProbePort Pin=via_45 Lower{LoadType=CoaxProbe Properties{Lower_R=0ohm Lower_L=0nH Lower_C=0pF Lower_Real=0ohm Lower_Imag=0ohm Lower_Magnitude=1V Lower_Phase=0deg Lower_Impedance=50ohm}} Material=copper ViaMesh=Wirebond Sides=3
setups:
  HFSS Setup 1: SolveSetupType=HFSS PercentRefinementPerPass=30 MinNumberOfPasses=1 MinNumberOfConvergedPasses=1 Frequency=10GHz MeshSizeFactor=1.5 ViaNumSides=6 ViaMaterial=copper Style25DVia=Mesh
    sweep Sweep 1: LIN 1GHz 4GHz 0.05GHz; FastSweep SAbsError=0.005 ZoPercentError=1 PassivityTolerance=0.0001 MaxSolutions=250 InterpUseSMatrix InterpUsePortImpedance InterpUseFullBasis MagMinThreshold=0.01
reports:
  Gain Plot 1: dB(GainInput) vs Theta on HFSS Setup 1 : Last Adaptive [Phi=-180deg F=2.45GHz]; markers m1 at 0deg, m2 at 30deg, m3 at -25deg, m4 at 98deg, m5 at -104deg, m6 at 179deg
  Antenna Params Table 1: Efficiency vs F on HFSS Setup 1 : Last Adaptive [Phi=-180deg Theta=-180deg]
  S Parameter Plot 1: dB(S(via_42,via_42)), dB(S(via_42,via_43)), dB(S(via_42,via_44)), dB(S(via_42,via_45)) vs F on HFSS Setup 1 : Sweep 1; markers m1 at 2.45GHz, m2 at 2.45GHz, m3 at 2.45GHz

design EMDesign1 (HFSS 3D Layout)
variables:
  x0 = y0
  y0 = 32.5mm  # optimise 20mm..40mm
  y1 = 10.5mm  # optimise 0mm..12mm
  W = 60mm
ports:
  via_6: Properties{Impedance=50ohm Magnitude=1V Phase=0deg Renormalize_Impedence="50ohm + 0i ohm" Renormalize Deembed_Distance=0mm Deembed Type=Probe HFSS_Type=Gap(coax) Orientation=Horizontal Layer_Alignment=Upper Horizontal_Extent_Factor=5 Vertical_Extent_Factor=3 PEC_Launch_Width=0mm} Type=ProbePort Pin=via_6 Lower{LoadType=CoaxProbe Properties{Lower_R=0ohm Lower_L=0nH Lower_C=0pF Lower_Real=0ohm Lower_Imag=0ohm Lower_Magnitude=1V Lower_Phase=0deg Lower_Impedance=50ohm}} Material=copper ViaMesh=Wirebond Sides=3
setups:
  HFSS Setup 1: SolveSetupType=HFSS PercentRefinementPerPass=30 MinNumberOfPasses=1 MinNumberOfConvergedPasses=1 Frequency=10GHz MeshSizeFactor=1.5 ViaNumSides=6 ViaMaterial=copper Style25DVia=Mesh
    sweep Sweep 1: LIN 2.4GHz 2.5GHz 0.01GHz; FastSweep SAbsError=0.005 ZoPercentError=1 PassivityTolerance=0.0001 MaxSolutions=250 InterpUseSMatrix InterpUsePortImpedance InterpUseFullBasis MagMinThreshold=0.01
optimetrics:
  OptimizationSetup1: Optimization Optimizer="Quasi Newton" AnalysisStopOptions{StopForNumIteration MaxNumIteration=1000 MinNumIteration=10} CostFuncNormType=L2 Acceptable_Cost=1 Noise=0.0001 UpdateDesignWhenDone
    vary y1: Min=0mm Max=12mm MinStep=0.1mm MaxStep=1mm MinFocus=0mm MaxFocus=12mm start=7.5mm
    goal VSWR(via_6) Minimize 0 weight 1 on HFSS Setup 1 : Last Adaptive at F 2.45GHz
reports:
  S Parameter Plot 1: dB(S(via_6,via_6)) vs F on HFSS Setup 1 : Sweep 1; markers m1 at 2.45GHz, m2 at 2.409487GHz, m3 at 2.4894609GHz
  VSWR Plot 1: VSWR(via_6) vs F on HFSS Setup 1 : Sweep 1
  Gain Plot 1: dB(GainEyAccepted) vs Theta on HFSS Setup 1 : Last Adaptive [Phi=0deg F=2.45GHz]; markers m1 at 0deg, m2 at 40deg, m3 at -40deg
