# Ansys Electronics Desktop project, version 2018.1
materials:
  air: permittivity=1.0006 permeability=1.0000004
  copper: permeability=0.999991 conductivity=58000000
  FR4_epoxy: permittivity=4.6 dielectric_loss_tangent=0.02
  pec: conductivity=1e+30
  vacuum: permittivity=1

design EMDesign1 (HFSS 3D Layout)
variables:
  a = 10.6mm  # optimise 5mm..15mm
  h0 = 5mm
  W2 = 0.155mm  # optimise 0.07mm..0.21mm
  W1 = 0.3mm
components:
  U13 = RLC_Parallel(EMInstanceName=RLC_Parallel:13 R=100ohm EnableC=false EnableL=false)
nets:
  InternalPort1: U13.0
  InternalPort2: U13.1
ports:
  Port1, Port2, Port3: Properties{Reference=bot:rect_27 Impedance=50ohm Magnitude=1V Phase=0deg Renormalize_Impedence="50ohm + 0i ohm" Renormalize Deembed_Distance=0mm Deembed Type="Single Strip Gap Source" HFSS_Type=Gap Orientation=Vertical Layer_Alignment=Upper Horizontal_Extent_Factor=5 Vertical_Extent_Factor=3 PEC_Launch_Width=0.03mm} Type=EdgePort
setups:
  HFSS Setup 1: SolveSetupType=HFSS PercentRefinementPerPass=30 MinNumberOfPasses=1 MinNumberOfConvergedPasses=1 Frequency=10GHz MeshSizeFactor=1.5 ViaNumSides=6 ViaMaterial=copper Style25DVia=Mesh
    sweep Sweep 1: LIN 1GHz 4GHz 0.05GHz; FastSweep SAbsError=0.005 ZoPercentError=1 PassivityTolerance=0.0001 MaxSolutions=250 InterpUseSMatrix InterpUsePortImpedance InterpUseFullBasis MagMinThreshold=0.01
reports:
  S Parameter Plot 2: dB(S(Port2,Port1)), dB(S(Port2,Port2)), dB(S(Port2,Port3)) vs F on HFSS Setup 1 : Sweep 1; markers m1 at 2.45GHz, m2 at 2.45GHz, m3 at 2.45GHz

design EMDesign2 (HFSS 3D Layout)
variables:
  a = 10.6mm  # optimise 5mm..15mm
  h0 = 5mm
  W2 = 0.155mm  # optimise 0.07mm..0.21mm
  W1 = 0.3mm
ports:
  Port1, Port2, Port3: Properties{Reference=bot:rect_27 Impedance=50ohm Magnitude=1V Phase=0deg Renormalize_Impedence="50ohm + 0i ohm" Renormalize Deembed_Distance=0mm Deembed Type="Single Strip Gap Source" HFSS_Type=Gap Orientation=Vertical Layer_Alignment=Upper Horizontal_Extent_Factor=5 Vertical_Extent_Factor=3 PEC_Launch_Width=0.03mm} Type=EdgePort
setups:
  HFSS Setup 1: SolveSetupType=HFSS PercentRefinementPerPass=30 MinNumberOfPasses=1 MinNumberOfConvergedPasses=1 Frequency=10GHz MeshSizeFactor=1.5 ViaNumSides=6 ViaMaterial=copper Style25DVia=Mesh
    sweep Sweep 1: LIN 1GHz 4GHz 0.05GHz; FastSweep SAbsError=0.005 ZoPercentError=1 PassivityTolerance=0.0001 MaxSolutions=250 InterpUseSMatrix InterpUsePortImpedance InterpUseFullBasis MagMinThreshold=0.01
reports:
  S Parameter Plot 2: dB(S(Port2,Port1)), dB(S(Port2,Port2)), dB(S(Port2,Port3)) vs F on HFSS Setup 1 : Sweep 1; markers m1 at 2.45GHz, m2 at 2.45GHz, m3 at 2.45GHz
